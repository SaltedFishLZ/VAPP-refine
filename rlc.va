`include "disciplines.vams"
`include "constants.vams"

`define attr(txt) (*txt*)

module rlc (p,n) `attr(xyceSpiceDeviceName="RLC" xyceLevelNumber="1");
  electrical p,n;
  inout p,n;
  electrical internal1, internal2;

  parameter real L=1e-3 from (0:inf) `attr(info="Inductance" type="instance");
  parameter real R=1e3 from (0:inf) `attr(info="Resistance" type="instance");
  parameter real C=1e-12 from (0:inf) `attr(info="Capacitance" type="instance");
  real InductorCurrent;
  real CapacitorCharge;

  analog
  begin

    I(p,internal1)<+ V(p,internal1)/R;

    CapacitorCharge = V(internal1,internal2)*C;
    I(internal1,internal2) <+ ddt(CapacitorCharge);

    InductorCurrent=I(internal2,n);
    V(internal2,n) <+ L*ddt(InductorCurrent);

  end
endmodule
